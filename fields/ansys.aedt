# Ansys Electronics Desktop project, version 2016.1
project variables:
  $spacing = 0.3175m
  $cutout = 4m
  $gap = $cutout + $spacing
  $outer = 7.0485m
  $inner = 5.7785m
  $length = 600m
materials:
  vacuum: permittivity=1
  copper: permeability=0.999991 conductivity=58000000

design Maxwell3DDesign1 (Maxwell 3D, Electrostatic, model units mm)
geometry:
  Cutout [copper] = cylinder(axis=Z, base_centre=(0mm, 0mm, -$length/2), radius=$outer, height=$length)
  Cylinder2 = cylinder(axis=Z, base_centre=(0mm, 0mm, -$length/2), radius=$inner, height=$length)
  Cutout.subtract(Cylinder2)
  Box1 = box(corner=(-$outer, 0mm, -$cutout/2), size=($outer*2, $outer, $cutout))
  Cylinder3 = cylinder(axis=X, base_centre=(-$outer, 0mm, 0mm), radius=$cutout /2, height=$outer*2)
  Cylinder3.unite(Box1)
  Cylinder4 = cylinder(axis=X, base_centre=(-$outer, 0mm, 0mm), radius=$gap /2, height=$outer*2)
  Box2 = box(corner=(-$outer, 0mm, -$gap/2), size=($outer*2, $outer, $gap))
  Cylinder4.unite(Box2)
  Cylinder4.subtract(Cylinder3)
  Cutout.subtract(Cylinder4)
  World [vacuum] = cylinder(axis=Z, base_centre=(0mm, 0mm, -$length/2), radius=1000mm, height=$length)
  Guide [copper] = Cutout.separate_bodies()
  GND [copper] = Guide.section(plane=XY)
  VDD [copper] = Cutout.section(plane=YZ)
  Cutout_Cross [non-model] = rectangle(corner=(-15mm, -15mm, 0), x_size=30mm, y_size=30mm)
boundaries and excitations:
  Sweep: Voltage Objects=VDD Voltage=1000V
  Ground: Voltage Objects=GND Voltage=0mV
setups:
  E_Field: Electrostatic MaximumPasses=20 MinimumPasses=2 MinimumConvergedPasses=2 PercentRefinement=30 PercentError=1
field plots:
  Mag_E1: E over a plane on E_Field : LastAdaptive
